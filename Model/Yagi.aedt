# Ansys Electronics Desktop project, version 2018.2
materials:
  vacuum: permittivity=1
  pec: conductivity=1e+30
  air: permittivity=1.0006 permeability=1.0000004
  copper: permeability=0.999991 conductivity=58000000
  FR4_epoxy: permittivity=4.4 dielectric_loss_tangent=0.02

design Dipole (HFSS, DrivenModal, model units mm)
variables:
  lambda = 10mm
  dip_rad = lambda/200
  radiation_rad = dip_rad+(lambda/4)
  gap_src = 0.125mm
  res_length = .475*lambda
  dip_length = res_length/2-(gap_src/2)
  radiation_height = gap_src/2+dip_length+lambda/10
geometry:
  dip1 [pec] = cylinder(axis=Z, base_centre=(0mm, 0mm, gap_src/2), radius=dip_rad, height=dip_length)
  dip1_1 [pec] = dip1.duplicate_around_axis(axis=X, angle=180deg, total=2)
  source = rectangle(corner=(0mm, -dip_rad, -gap_src/2), y_size=dip_rad*2, z_size=gap_src)
  radiation [air] = cylinder(axis=Z, base_centre=(0mm, 0mm, -radiation_height), radius=radiation_rad, height=radiation_height*2)
  Director#56 = part_of(#45)
  Director#56.delete()
  Driver#66 = part_of(#45)
  Driver#66.delete()
  Gnd#150 = part_of(#45)
  Gnd#150.delete()
  substrate#160 = part_of(#45)
  substrate#160.delete()
  airbox = part_of(#45)
  airbox.delete()
  port#214 = part_of(#45)
  port#214.delete()
  Director#234 = part_of(#224)
  Director#234.delete()
  Driver#244 = part_of(#224)
  Driver#244.delete()
  Gnd#328 = part_of(#224)
  Gnd#328.delete()
  substrate#338 = part_of(#224)
  substrate#338.delete()
  port#365 = part_of(#224)
  port#365.delete()
boundaries and excitations:
  Rad1: Radiation Faces=radiation.face(all 3)
  source: Lumped Port Objects=source Modes{Mode1{IntLine{middle of source.edge(z at corner) -> source.face} CharImp=Zpi RenormImp=50ohm}} Impedance=70.2283ohm
setups:
  Setup1: HfssDriven Frequency=29.9792GHz MaxDeltaS=0.02 MaximumPasses=20 MinimumPasses=1 MinimumConvergedPasses=1 PercentRefinement=30 BasisOrder=1 PortAccuracy=2
    sweep Sweep: 25GHz to 35GHz, 1000 points; Type=Fast SaveFields
source amplitudes:
  source:1: 1W 0deg
radiation setups:
  Infinite Sphere1: Infinite Sphere Theta=0deg..180deg step 2deg Phi=-180deg..180deg step 2deg
reports:
  Z Parameter Plot 1: re(Z(source,source)), im(Z(source,source)) vs Freq on Setup1 : Sweep; markers m1 at 29.924925GHz, m2 at 29.9249GHz
  S Parameter Plot 1: dB(S(source,source)) vs Freq on Setup1 : Sweep; markers m1 at 29.664665GHz

design Yagi (HFSS, DrivenModal, model units mm)
variables:
  rod_r = 3.2mm
  drv_l = 325.57mm
  ref_l = 328.45mm
  dir1_l = 302.96mm
  dir2_l = 301mm
  dir3_l = 290.21mm
  dir4_l = 288.74mm
  dir5_l = 281.39mm
  gap_w = 0.5mm
  drv_dir1_d = 120.18mm
  ref_drv_d = 182.47mm
  dir1_dir2_d = 128.57mm
  dir2_dir3_d = 167.14mm
  dir3_dir4_d = 155.27mm
  dir4_dir5_d = 172.09mm
  ref_p = -ref_drv_d
  dir1_p = drv_dir1_d
  dir2_p = dir1_p+dir1_dir2_d
  dir3_p = dir2_p+dir2_dir3_d
  dir4_p = dir3_p+dir3_dir4_d
  dir5_p = dir4_p+dir4_dir5_d
geometry:
  Driver [pec] = cylinder(axis=Z, base_centre=(0mm, 0mm, gap_w/2), radius=rod_r, height=drv_l/2)
  Director1 [pec] = cylinder(axis=Z, base_centre=(0mm, dir1_p, -dir1_l/2), radius=rod_r, height=dir1_l)
  Director2 [pec] = cylinder(axis=Z, base_centre=(0mm, dir2_p, -dir2_l/2), radius=rod_r, height=dir2_l)
  Reflector [pec] = cylinder(axis=Z, base_centre=(0mm, ref_p, -ref_l/2), radius=rod_r, height=ref_l)
  Driver.duplicate_around_axis(axis=Y, angle=180deg, total=2, attached)
  source = rectangle(corner=(0mm, -rod_r, -gap_w/2), y_size=rod_r*2, z_size=gap_w)
  radiation [air] = cone(axis=Y, base_centre=(0mm, -547.41mm, 0mm), bottom_radius=562.78mm, top_radius=562.78mm, height=2594.69mm)
  Director3 [pec] = cylinder(axis=Z, base_centre=(0mm, dir3_p, -dir3_l/2), radius=rod_r, height=dir3_l)
  Director4 [pec] = cylinder(axis=Z, base_centre=(0mm, dir4_p, -dir4_l/2), radius=rod_r, height=dir4_l)
  Director5 [pec] = cylinder(axis=Z, base_centre=(0mm, dir5_p, -dir5_l/2), radius=rod_r, height=dir5_l)
boundaries and excitations:
  Rad1: Radiation Faces=radiation.face(all 3)
  source: Lumped Port Objects=source Modes{Mode1{IntLine{middle of source.edge(z at corner) -> middle of source.edge(z opposite corner)} CharImp=Zpi RenormImp=50ohm}} Impedance=50ohm
mesh:
  Length1: LengthBased Objects=[Driver, Director1, Director2, Reflector, source, Director3, Director4, Director5] MaxLength=370.288mm
  initial mesh: GlobalSurfApproximation{CurvedSurfaceApproxChoice=UseSlider SliderMeshSettings=3}
setups:
  Setup1: HfssDriven Frequency=435MHz MaxDeltaS=0.04 MaximumPasses=15 MinimumPasses=1 MinimumConvergedPasses=1 PercentRefinement=30 BasisOrder=1 PortAccuracy=2 UseDomains DDMSolverResidual=0.0001
    sweep Sweep: 430MHz to 440MHz, 10 points; disabled Type=Fast SaveFields
source amplitudes:
  source:1: 1W 0deg
radiation setups:
  Infinite Sphere1: Infinite Sphere Theta=0deg..180deg step 2deg Phi=-180deg..180deg step 2deg
output variables:
  directivity = DirTotal
  directivity1 = rod_r
field plots:
  Mesh4: MeshPlots over Director1.face(all 3) Director2.face(all 3) Director3.face(all 3) Director4.face(all 3) Director5.face(all 3) Driver.face(all 6) Reflector.face(all 3) on Setup1 : LastAdaptive at Freq=0.435GHz Phase=0deg
reports:
  Gain Plot 1: GainTotal vs Phi, Theta on Setup1 : LastAdaptive, Infinite Sphere1 [Freq=0.435GHz]
  AntennaReward: DirTotal vs Phi on Setup1 : LastAdaptive, Infinite Sphere1 [Theta=90deg Phi=90deg Freq=0.435GHz]
  AntennaStates: MaxU vs Freq on Setup1 : LastAdaptive; FrontToBackRatio, MaxrETotal, AcceptedPower, RadiatedPower vs Freq
